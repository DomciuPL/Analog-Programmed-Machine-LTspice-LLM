* APM-1: RAF_LORENZ_SCENARIO_APM1
* Original description: ../docs/examples/RAF_LORENZ_SCENARIO_APM1_original.txt
* Current instructions and interpretation: ../docs/advanced_examples_pl.md
* Author of original examples: Dariusz Domal

.include "../apm1_lib.txt"
.param VL=10
.param VDD=10
.param F0=440
.param Tdot=100m
.param Tcycle=600m

V1 sin 0 SINE(0 {VL} {F0})

V_DOT  ctrl_dot  0  PULSE(0 {VDD} 0 1m 1m {Tdot}  {Tcycle})
B_DASH ctrl_dash 0  V = {VDD} - V(ctrl_dot)

V_S s 0 PWL( 0 0.5  5 0.5  15 1.0  30 0.1  45 0.55  60 0.8 )

B_WDOT  wdot  0 V={ 1 - V(s) }
B_WDASH wdash 0 V={ V(s) }

B_GDOT  gdot  0 V={ V(ctrl_dot)/VDD*VL }
B_GDASH gdash 0 V={ V(ctrl_dash)/VDD*VL }

XMUL_GDOT  sin_dot  sin   gdot  0 MUL PARAMS: VL={VL}
XMUL_GDASH sin_dash sin   gdash 0 MUL PARAMS: VL={VL}

XMUL_WDOT  y_dot   sin_dot  wdot  0 MUL PARAMS: VL=1
XMUL_WDASH y_dash  sin_dash wdash 0 MUL PARAMS: VL=1

XSUM  ac_pre  y_dot  y_dash  0 SUM PARAMS: Ku=1 Kd=1

C_AC   ac_pre acout 10u
R_AC   acout  0     600

.options plotwinsize=0 method=gear maxord=2 trtol=5 reltol=1e-6 abstol=1e-9 vntol=1e-9
.tran 0 60 0 1m

B_AUDIO audio 0 V={0.8*V(acout)/VL}
*=== RESULTS_BEGIN ===
.meas tran Audio_peak MAX abs(V(audio)) FROM=1 TO=60
.meas tran Audio_rms RMS V(audio) FROM=1 TO=5
*=== RESULTS_END ===
.wave RAF_LORENZ_SCENARIO_APM1.wav 16 44.1k V(audio)

.end
