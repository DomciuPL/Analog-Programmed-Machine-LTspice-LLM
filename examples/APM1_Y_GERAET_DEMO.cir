* APM-1: APM1_Y_GERAET_DEMO
* Original description: ../docs/examples/APM1_Y_GERAET_DEMO_original.txt
* Current instructions and interpretation: ../docs/advanced_examples_pl.md
* Author of original examples: Dariusz Domal

.include "../apm1_lib.txt"
.param VL=10

.param L_T   = 4       ; odległość nadajnik–cel: 4 V  40 km
.param x0    = 0       ; pozycja początkowa: przy nadajniku
.param v     = 0.1     ; prędkość wzdłuż wiązki: 0.1 V/s  1 km/s

.param x_jam = 0       ; [V]  10 km/V

.param tstop   = 50
.param maxstep = 0.01

.options plotwinsize=0
.options method=gear maxord=2 trtol=5 reltol=1e-6 abstol=1e-9 vntol=1e-9

B_TIME t 0 V = time
R_TIME t 0 1G

V_VEL vx 0 DC {v}
XINT_X x vx 0 INTpinv IC={x0} K=1 leak=0

XGAIN_XKM x_km x 0 GAIN K=10

V_XTARG xT 0 DC {L_T}

XERR_IDE e_ideal xT x 0 SUM Ku=1 Kd=-1

XCMP_IDE flag_ideal e_ideal 0 0 CMPad th=0

XEDGE_IDE pulse_ideal flag_ideal 0 EDGE_F Td=0.02

V_JAM vjam 0 DC {x_jam}
XSUM_MEAS x_meas x vjam 0 SUM Ku=1 Kd=1

XERR_Y e_Y xT x_meas 0 SUM Ku=1 Kd=-1

XCMP_Y flag_Y e_Y 0 0 CMPad th=0

XEDGE_Y pulse_Y flag_Y 0 EDGE_F Td=0.02

.tran 0 {tstop} 0 {maxstep}

*=== RESULTS_BEGIN ===

.meas tran t_rel_ideal WHEN V(pulse_ideal)=0.5 RISE=1

.meas tran t_rel_Y     WHEN V(pulse_Y)=0.5 RISE=1

.meas tran dT_err  PARAM='( t_rel_Y - t_rel_ideal )'

.meas tran dX_err  PARAM='( {v} * dT_err * 10 )'

*=== RESULTS_END ===

.end
