* APM-1: KNICKEBEIN_APM1
* Original description: ../docs/examples/KNICKEBEIN_APM1_original.txt
* Current instructions and interpretation: ../docs/advanced_examples_pl.md
* Author of original examples: Dariusz Domal

.include "../apm1_lib.txt"
.param VL=10
.param F0=440
.param Tdot=100m
.param Tcycle=600m

V_CAR carr 0 SINE(0 {VL} {F0})

V_DOT  ctrl_dot  0  PULSE(0 {VL} 0 1m 1m {Tdot} {Tcycle})
B_DASH ctrl_dash 0  V={ VL - V(ctrl_dot) }

V_SA sa 0 PWL( 0 0.5   20 0.5   40 0.2   60 0.8   80 0.5   100 0.5 )

V_SB sb 0 PWL( 0 0.0   20 0.0   40 0.2   60 0.5   80 0.5   100 0.8 )

XMUL_GDOT_A   carr_dotA  carr  ctrl_dot   0  MUL PARAMS: VL={VL}
XMUL_GDASH_A  carr_dashA carr  ctrl_dash  0  MUL PARAMS: VL={VL}

B_WDOTA  wdotA  0  V={ (1 - V(sa))*VL }
B_WDASHA wdashA 0  V={ V(sa)*VL }

XMUL_WDOT_A   dotA  carr_dotA  wdotA   0  MUL PARAMS: VL={VL}
XMUL_WDASH_A  dashA carr_dashA wdashA  0  MUL PARAMS: VL={VL}

XSUM_A  beamA  dotA  dashA  0  SUM PARAMS: Ku=1 Kd=1
C_ACA  beamA  acA  10u
R_ACA  acA    0    600

XMUL_GDOT_B   carr_dotB  carr  ctrl_dot   0  MUL PARAMS: VL={VL}
XMUL_GDASH_B  carr_dashB carr  ctrl_dash  0  MUL PARAMS: VL={VL}

B_WDOTB  wdotB  0  V={ (1 - V(sb))*VL }
B_WDASHB wdashB 0  V={ V(sb)*VL }

XMUL_WDOT_B   dotB  carr_dotB  wdotB   0  MUL PARAMS: VL={VL}
XMUL_WDASH_B  dashB carr_dashB wdashB  0  MUL PARAMS: VL={VL}

XSUM_B  beamB  dotB  dashB  0  SUM PARAMS: Ku=1 Kd=1
C_ACB  beamB  acB  10u
R_ACB  acB    0    600

XSUM_AB ac_mix acA acB 0 SUM PARAMS: Ku=0.5 Kd=0.5

.options plotwinsize=0 method=gear maxord=2 trtol=5 reltol=1e-6 abstol=1e-9 vntol=1e-9
.tran 0 100 0 1m

B_AUDIO_A audio_a 0 V={0.8*V(acA)/VL}
B_AUDIO_B audio_b 0 V={0.8*V(acB)/VL}
*=== RESULTS_BEGIN ===
.meas tran Audio_A_peak MAX abs(V(audio_a)) FROM=1 TO=100
.meas tran Audio_B_peak MAX abs(V(audio_b)) FROM=1 TO=100
*=== RESULTS_END ===
.wave KNICKEBEIN_APM1.wav 16 44.1k V(audio_a) V(audio_b)

.end
