* APM-1: APM1_OBOE_DEMO
* Original description: ../docs/examples/APM1_OBOE_DEMO_original.txt
* Current instructions and interpretation: ../docs/advanced_examples_pl.md
* Author of original examples: Dariusz Domal

.include "../apm1_lib.txt"
.param VL=10

.param R_CAT   = 4      ; promień okręgu Cat  40 km
.param D_CM    = 6      ; odległość Cat–Mouse  60 km
.param R_MOUSE = 4      ; promień okręgu Mouse (promień zrzutu)

.param phi0  = -0.5     ; pozycja początkowa (rad), punkt przed celem
.param omega = 0.04     ; dφ/dt [rad/s], prędkość kątowa

.param phi_T = { acos( (R_CAT*R_CAT + D_CM*D_CM - R_MOUSE*R_MOUSE) / (2*R_CAT*D_CM) ) }

.param t_ideal = { (phi_T - phi0)/omega }

.param r_jam = 0

.param tstop   = 80
.param maxstep = 0.01

.options plotwinsize=0
.options method=gear maxord=2 trtol=5 reltol=1e-6 abstol=1e-9 vntol=1e-9

V_OMEGA vphi 0 DC {omega}
XINT_PHI phi vphi 0 INTpinv IC={phi0} K=1 leak=0

B_X x 0 V = { R_CAT * cos(V(phi)) }
R_X x 0 1G

B_Y y 0 V = { R_CAT * sin(V(phi)) }
R_Y y 0 1G

B_RCAT r_cat 0 V = { sqrt( V(x)*V(x) + V(y)*V(y) ) }
R_RCAT r_cat 0 1G

V_DCM dcm 0 DC {D_CM}

B_RMOUSE r_mouse 0 V = { sqrt( (V(x)-V(dcm))*(V(x)-V(dcm)) + V(y)*V(y) ) }
R_RMOUSE r_mouse 0 1G

V_RCAT_REF rcat_ref 0 DC {R_CAT}
XERR_CAT e_cat rcat_ref r_cat 0 SUM Ku=1 Kd=-1

B_RM_MEAS rM_meas 0 V = { V(r_mouse) + r_jam }
R_RM_MEAS rM_meas 0 1G

V_RM_REF rm_ref 0 DC {R_MOUSE}
XERR_M e_M rm_ref rM_meas 0 SUM Ku=1 Kd=-1

XCMP_M flag_M e_M 0 0 CMPad th=0

XEDGE_M pulse_M flag_M 0 EDGE_F Td=0.02

.tran 0 {tstop} 0 {maxstep}

*=== RESULTS_BEGIN ===

.meas tran t_drop WHEN V(pulse_M)=0.5 RISE=1

.meas tran dT_err PARAM='( t_drop - {t_ideal} )'

.meas tran rcat_drop   FIND V(r_cat)   WHEN V(pulse_M)=0.5 RISE=1
.meas tran rmouse_drop FIND V(r_mouse) WHEN V(pulse_M)=0.5 RISE=1

*=== RESULTS_END ===

.end
