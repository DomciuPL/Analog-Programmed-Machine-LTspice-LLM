* APM-1: Helisa_apm_1_
* Original description: ../docs/examples/Helisa_apm_1_original.txt
* Current instructions and interpretation: ../docs/advanced_examples_pl.md
* Author of original examples: Dariusz Domal

.include "../apm1_lib.txt"
.param VL=10

.param R_nm=1.0
.param bp_per_turn=10.5
.param rise_bp_nm=0.34
.param pitch_nm = {bp_per_turn*rise_bp_nm}          ; 3.57 nm/turn

.param F=5
.param nm2VL=1
.param R   ={nm2VL*R_nm}                             ; radius [VL]
.param P   ={F*pitch_nm*nm2VL}                       ; z(t)=P·t

.param alpha_minor = {2*pi*12/34}                    ; 127.06°
.param alpha_major = {2*pi - alpha_minor}            ; 232.94°
.param phi_sep     = {alpha_minor}

.param LEAKi = 0             ; exact geometric integrals; leak>0 changes pitch
.param g=0                   ; optional tiny radial modulation
.param fproj = {10*R}        ; focal length in [VL]
.param dth = {2*pi/bp_per_turn}   ; turn per single base pair

Vone one 0 DC 1

Xz   z   one 0 INTp  IC=0  SIGN=+1  K={P}          LEAK={LEAKi}
Xth  th  one 0 INTp  IC=0  SIGN=+1  K={2*pi*F}     LEAK={LEAKi}

B_r1  r1  0  V={ R + g*cos(V(th)) }
R_r1  r1  0  1G
B_r2  r2  0  V={ R - g*cos(V(th)) }
R_r2  r2  0  1G

B_phi1  phi1 0  V={ V(th) }
R_phi1  phi1 0  1G
B_phi2  phi2 0  V={ V(th) + phi_sep }
R_phi2  phi2 0  1G

B_x1  x1  0  V={ V(r1)*cos(V(phi1)) }
R_x1  x1  0  1G
B_y1  y1  0  V={ V(r1)*sin(V(phi1)) }
R_y1  y1  0  1G
B_x2  x2  0  V={ V(r2)*cos(V(phi2)) }
R_x2  x2  0  1G
B_y2  y2  0  V={ V(r2)*sin(V(phi2)) }
R_y2  y2  0  1G

B_den  den 0  V={ 1 + V(z)/fproj }
R_den  den 0  1G
B_w    w   0  V={ VL / V(den) }
R_w    w   0  1G
Xx1p   x1p x1 w 0 DPT VL={VL}
Xx2p   x2p x2 w 0 DPT VL={VL}
Xy1p   y1p y1 w 0 DPT VL={VL}
Xy2p   y2p y2 w 0 DPT VL={VL}
B_zp   zp  0  V={ V(z)/V(den) }
R_zp   zp  0  1G

B_dx  dx  0  V={ V(x2) - V(x1) }
R_dx  dx  0  1G
B_dy  dy  0  V={ V(y2) - V(y1) }
R_dy  dy  0  1G
B_gap gap 0  V={ sqrt( V(dx)*V(dx) + V(dy)*V(dy) ) }
R_gap gap 0  1G

B_cosd  cosd 0  V={ (V(x1)*V(x2)+V(y1)*V(y2)) / max(1e-12, V(r1)*V(r2)) }
R_cosd  cosd 0  1G
B_dphi  dphi 0  V={ acos( limit(V(cosd), -1, 1) ) }
R_dphi  dphi 0  1G

B_bpidx bpidx 0  V={ V(th)/dth }
R_bpidx bpidx 0  1G
B_phase phase 0  V={ V(th)/(2*pi) - floor(V(th)/(2*pi)) }
R_phase phase 0  1G

.param T_STOP=1
.save V(r1) V(r2) V(z) V(th) V(x1) V(y1) V(x2) V(y2) V(x1p) V(y1p) V(x2p) V(y2p) V(zp) V(den) V(w) V(dx) V(dy) V(gap) V(cosd) V(dphi) V(bpidx) V(phase)

*=== RESULTS_BEGIN ===
.meas tran r1_avg        AVG  V(r1)    FROM 0 TO {T_STOP}
.meas tran r2_avg        AVG  V(r2)    FROM 0 TO {T_STOP}
.meas tran z_end         FIND V(z)     AT   {T_STOP}
.meas tran th_end        FIND V(th)    AT   {T_STOP}
.meas tran w_min         MIN  V(w)     FROM 0 TO {T_STOP}
.meas tran w_max         MAX  V(w)     FROM 0 TO {T_STOP}
.meas tran x1p_q         FIND V(x1p)   AT   {0.25*T_STOP}
.meas tran y1p_q         FIND V(y1p)   AT   {0.25*T_STOP}
.meas tran x2p_q         FIND V(x2p)   AT   {0.25*T_STOP}
.meas tran y2p_q         FIND V(y2p)   AT   {0.25*T_STOP}

.meas tran s_minor       PARAM='{R}*{alpha_minor}'
.meas tran s_major       PARAM='{R}*{alpha_major}'
.meas tran groove_ratio  PARAM='{s_major/s_minor}'

.meas tran pitch_est     PARAM='{z_end}/{F}'
.meas tran dphi_avg      AVG   V(dphi) FROM 0 TO {T_STOP}
.meas tran dphi_err      PARAM='{dphi_avg - alpha_minor}'
*=== RESULTS_END ===

.options method=gear maxord=2 trtol=5 reltol=1e-6 abstol=1e-9 vntol=1e-9 gmin=1e-12 cshunt=1e-15 plotwinsize=0
.tran 0 {T_STOP} 0 {T_STOP/2000}
.end
