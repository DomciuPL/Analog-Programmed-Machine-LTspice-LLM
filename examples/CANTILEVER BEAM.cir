* APM-1: CANTILEVER BEAM
* Original description: ../docs/examples/CANTILEVER_BEAM_original.txt
* Current instructions and interpretation: ../docs/advanced_examples_pl.md
* Author of original examples: Dariusz Domal

.include "../apm1_lib.txt"
.include "../apm1_wob_lib.txt"
.param L_real   = 10      ; Długość skrzydła [m]
.param EI       = 2.5e6   ; Sztywność giętna (Elasticity * Inertia) [Nm^2]
.param Q_max    = 5000    ; Obciążenie u nasady [N/m]

.param VL       = 10      ; Napięcie Maszynowe (Unit Machine Unit)
.param Tsim     = 1       ; Czas symulacji odpowiadający długości L
.param K_space  = {L_real / Tsim}

.param R0_val = { (2/3) * Q_max * L_real }        ; Siła tnąca w utwierdzeniu [N]
.param M0_val = { -0.25 * Q_max * (L_real**2) }   ; Moment gnący w utwierdzeniu [Nm]

XWOB x_pos 0 WOBLIN PARAMS: VL={VL} T={Tsim}

B_xi xi 0 V = { V(x_pos,0) / VL }

XSQ xi2 xi xi 0 MUL PARAMS: VL=1
B_Load q_load 0 V = { Q_max * (1 - V(xi2,0)) }

XINT_T shear q_load 0 INTp PARAMS: IC={R0_val} SIGN=-1 K={K_space}

XINT_M moment shear 0 INTp PARAMS: IC={M0_val} SIGN=1 K={K_space}

B_Curv kappa 0 V = { V(moment,0) / EI }

XINT_S slope kappa 0 INTp PARAMS: IC=0 SIGN=1 K={K_space}

XINT_Y deflect slope 0 INTp PARAMS: IC=0 SIGN=1 K={K_space}

B_VISUAL def_visual 0 V = { -V(deflect,0) }

.options method=gear reltol=1e-6 abstol=1e-9 vntol=1e-9 plotwinsize=0
.tran 0 {Tsim} 0 100u

*=== RESULTS_BEGIN ===
.meas TRAN Error_Shear_Tip FIND V(shear) AT={Tsim}
.meas TRAN Error_Moment_Tip FIND V(moment) AT={Tsim}

.meas TRAN Tip_Deflection_Meters FIND V(deflect) AT={Tsim}
*=== RESULTS_END ===

.end
