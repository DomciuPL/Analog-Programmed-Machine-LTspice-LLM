* APM-1: Memory
* Original description: ../docs/examples/Memory_original.txt
* Current instructions and interpretation: ../docs/advanced_examples_pl.md
* Author of original examples: Dariusz Domal

.include "../apm1_lib.txt"
.param VL     = 10           ; napięcie maszynowe ("1")
.param NBIT   = 10           ; liczba bitów w słowie
.param BIT_T  = 2u           ; czas jednej szczeliny bitowej
.param T0     = 1u           ; początek słowa (pierwszy bit b9)
.param tau    = {NBIT*BIT_T} ; czas opóźnienia linii = długość słowa
.param TLOAD  = {T0+tau}     ; chwila przełączenia na recyrkulację

.options plotwinsize=0 method=gear reltol=1e-6 abstol=1e-9 vntol=1e-9

BWRITE write 0 V =
+ if( time < {T0}, 0,
+ if( time >= {T0+NBIT*BIT_T}, 0,
+ {VL}*table( int( (time-{T0})/{BIT_T} ),
+   0  1
+   1  1
+   2  1
+   3  1
+   4  1
+   5  0
+   6  0
+   7  1
+   8  0
+   9  1 )))

BLOOP nIN_LOOP 0 V = if( time < {TLOAD}, V(write,0), V(BIT_SHAPED,0) )

XDL nDELAY_RAW nIN_LOOP 0 DELAY PARAMS: T={tau}

XCMP  LOGIC_RAW nDELAY_RAW 0 0 CMPad PARAMS: th={VL/2}
XGAIN BIT_SHAPED LOGIC_RAW 0 GAIN PARAMS: K={VL}

.tran 0 200u 0 50n

*=== RESULTS_BEGIN ===
.meas TRAN t_rise10 WHEN V(BIT_SHAPED,0)={VL/2} RISE=10
.meas TRAN t_rise12 WHEN V(BIT_SHAPED,0)={VL/2} RISE=12
.meas TRAN Tloop    PARAM='t_rise12 - t_rise10'
*=== RESULTS_END ===

B_AUDIO_IN audio_in 0 V={V(nIN_LOOP)/VL}
B_AUDIO_RAW audio_raw 0 V={V(nDELAY_RAW)/VL}
B_AUDIO_OUT audio_out 0 V={V(BIT_SHAPED)/VL}
.wave "memory_997_diagnostic.wav" 16 10Meg V(audio_in) V(audio_raw) V(audio_out)
.end
