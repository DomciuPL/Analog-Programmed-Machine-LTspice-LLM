* APM-1: APM1_TRI2SQ_A1_F200_v1
* Original description: ../docs/examples/APM1_TRI2SQ_A1_F200_v1_original.txt
* Current instructions and interpretation: ../docs/advanced_examples_pl.md
* Author of original examples: Dariusz Domal

.include "../apm1_lib.txt"
.param VL=10                 ; machine voltage unit
.param A=1                   ; triangle amplitude (±A)
.param f0=200                ; frequency [Hz]
.param T0={1/f0}             ; period

XONE  one   0  CLK  f=1     duty=1   vhi=1  vlo=1           ; constant “1”
XCLK  s01   0  CLK  f={f0}  duty=0.5 vhi=1  vlo=0           ; 0/1 clock

XPM1  spm1  s01 one 0  ADD2W  wa=2     wb=-1   scale=1      ; spm1 in {-1,+1}

XGIN  u_int spm1 0    GAIN  K={4*A*f0}
XINT  tri   u_int 0   INT   IC={-A} SIGN=1  leak=0

XDIF  y_raw tri 0  DIF  K={-1/(4*A*f0)}  leak=0
XLIM  y     y_raw 0  LIM  L=-1  H=1

XMAP  y01   y  one 0  ADD2W  wa=0.5  wb=0.5  scale=1

.options plotwinsize=0 method=gear maxord=2 trtol=5 reltol=1e-6 abstol=1e-9 vntol=1e-9
.tran 0 20m 0 1u
.save V(tri) V(y) V(y01) V(s01)

.param eps={0.1*T0}      ; edge margin
.param k=2               ; which period to evaluate

*=== RESULTS_BEGIN ===
.meas tran Y_abs    AVG  abs(V(y)) FROM={k*T0}               TO={(k+1)*T0}
.meas tran Y01_dut  AVG  V(y01)    FROM={k*T0}               TO={(k+1)*T0}
.meas tran Y_neg    AVG  V(y)      FROM={k*T0+eps}           TO={k*T0+T0/2-eps}
.meas tran Y_pos    AVG  V(y)      FROM={k*T0+T0/2+eps}      TO={(k+1)*T0-eps}
.meas tran TRI_MIN MIN V(tri) FROM=5m TO=20m
.meas tran TRI_MAX MAX V(tri) FROM=5m TO=20m
*=== RESULTS_END ===

.end
