* Compatibility entry point; canonical example and measurements are included.
.include "examples/03_division.cir"
