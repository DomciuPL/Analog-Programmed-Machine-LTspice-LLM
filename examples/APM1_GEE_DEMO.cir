* APM-1: APM1_GEE_DEMO
* Original description: ../docs/examples/APM1_GEE_DEMO_original.txt
* Current instructions and interpretation: ../docs/advanced_examples_pl.md
* Author of original examples: Dariusz Domal

.include "../apm1_lib.txt"
.param VL      = 10            ; Napięcie maszynowe APM-1
.param Xscale  = 20            ; [km/V] Skala przestrzenna. 1V w symulacji = 20 km w rzeczywistości.
.param Tscale  = 100           ; [s rzeczywiste / s symulacji] Skala czasowa. 1s symulacji = 100s lotu.
.param c_km_s  = 299792.458    ; Prędkość światła [km/s]

.param GEE_d_km  = 20          ; Różnica drogi [km] dla 1 jednostki Gee
.param GEE_T_us  = {1e6*GEE_d_km/c_km_s} ; modelowa jednostka czasu [µs]

.param D_MB_km = 200           ; Baza A–B [km]
.param D_MC_km = 200           ; współrzędna Y stacji C [km], nie odległość A–C

.param xA = { -D_MB_km/2/Xscale }   ; = -5 V  (-100 km)
.param yA = 0
.param xB = {  D_MB_km/2/Xscale }   ; = +5 V  (+100 km)
.param yB = 0
.param xC = 0
.param yC = { D_MC_km/Xscale }      ; = +10 V (+200 km)

.param V_kmh    = 400          ; Prędkość przelotowa [km/h]
.param Vx_frac  = 0.7          ; waga kierunku X przed normalizacją
.param Vy_frac  = 0.3          ; waga kierunku Y przed normalizacją
.param direction_norm = {sqrt(Vx_frac**2+Vy_frac**2)}

.param Vx_phys  = { V_kmh/3600*Vx_frac/direction_norm } ; Prędkość fizyczna [km/s]
.param Vy_phys  = { V_kmh/3600*Vy_frac/direction_norm } ; Prędkość fizyczna [km/s]

.param vx_sim   = { Vx_phys*Tscale/Xscale }
.param vy_sim   = { Vy_phys*Tscale/Xscale }

.param x0 = -4                  ; -4 V  => -80 km
.param y0 = -3                  ; -3 V  => -60 km

Vvx vx 0 DC {vx_sim}
Vvy vy 0 DC {vy_sim}

XINT_X x vx 0 INTpinv IC={x0} K=1 leak=0
XINT_Y y vy 0 INTpinv IC={y0} K=1 leak=0

B_rA rA 0 V = { sqrt( (V(x)-{xA})**2 + (V(y)-{yA})**2 ) }
B_rB rB 0 V = { sqrt( (V(x)-{xB})**2 + (V(y)-{yB})**2 ) }
B_rC rC 0 V = { sqrt( (V(x)-{xC})**2 + (V(y)-{yC})**2 ) }

R_rA rA 0 1G
R_rB rB 0 1G
R_rC rC 0 1G

B_dMB dMB 0 V = { V(rB) - V(rA) }
B_dMC dMC 0 V = { V(rC) - V(rA) }

R_dMB dMB 0 1G
R_dMC dMC 0 1G

B_tMB tMB 0 V = { (V(dMB)*Xscale/{c_km_s})*1e6 }  ; [µs]
B_tMC tMC 0 V = { (V(dMC)*Xscale/{c_km_s})*1e6 }  ; [µs]

R_tMB tMB 0 1G
R_tMC tMC 0 1G

B_uMB uMB 0 V = { V(tMB)/{GEE_T_us} }
B_uMC uMC 0 V = { V(tMC)/{GEE_T_us} }

R_uMB uMB 0 1G
R_uMC uMC 0 1G

.param T_end   = 2           ; Czas symulacji [s] (odpowiada 200s lotu)
.param maxstep = {T_end/2000}

.options plotwinsize=0 method=gear maxord=2 trtol=5 reltol=1e-6
.options abstol=1e-9 vntol=1e-9

.tran 0 {T_end} 0 {maxstep}

*=== RESULTS_BEGIN ===
.meas tran x_final  FIND V(x) AT={T_end}
.meas tran y_final  FIND V(y) AT={T_end}
.meas tran dMB_end  FIND V(dMB) AT={T_end}
.meas tran dMC_end  FIND V(dMC) AT={T_end}
.meas tran tMB_end  FIND V(tMB) AT={T_end}
.meas tran tMC_end  FIND V(tMC) AT={T_end}
.meas tran speed_error PARAM abs(3600*sqrt(Vx_phys**2+Vy_phys**2)-V_kmh)
*=== RESULTS_END ===

.end
