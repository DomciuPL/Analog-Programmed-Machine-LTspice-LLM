* APM-1: leakage, bounded wind-up recovery and actual state reset
.include "../apm1_lib.txt"
.param VL=10 LeakRate=1
.step param LeakRate list 0 1
Vone one 0 1
XLEAK decay 0 0 INT IC=2 SIGN=1 leak={LeakRate}
Vaw u_aw 0 PWL(0 4 2 4 2.00001 -1 3.5 -1)
XAW limited u_aw 0 INTV IC=0 SIGN=1 L=0 H=1 leak=0 Taw=20m
Vreset rst 0 PULSE(0 1 1 1u 1u 100m 10)
XRST reset_state one rst 0 RSTINT IC=0.25 SIGN=1 leak=0 Tr=1m
.options method=gear reltol=1e-7 abstol=1e-10 vntol=1e-9 plotwinsize=0
.tran 0 3.5 0 100u
.save V(decay) V(limited) V(reset_state) V(rst)
*=== RESULTS_BEGIN ===
.meas tran decay_at_1 FIND V(decay) AT=1
.meas tran decay_error PARAM abs(decay_at_1-2*exp(-LeakRate))
.meas tran limit_peak MAX V(limited) FROM=0 TO=3.5
.meas tran limit_peak_error PARAM abs(limit_peak-1)
.meas tran recovery_value FIND V(limited) AT=2.5
.meas tran recovery_error PARAM abs(recovery_value-(0.5+0.02*ln(5)))
.meas tran reset_high FIND V(reset_state) AT=1.09
.meas tran reset_after FIND V(reset_state) AT=2
.meas tran reset_high_error PARAM abs(reset_high-0.25)
.meas tran reset_after_error PARAM abs(reset_after-1.15)
*=== RESULTS_END ===
.end
