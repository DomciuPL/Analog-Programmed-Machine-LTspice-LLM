* APM-1: X_GERAET_DEMO
* Original description: ../docs/examples/X_GERAET_DEMO_original.txt
* Current instructions and interpretation: ../docs/advanced_examples_pl.md
* Author of original examples: Dariusz Domal

.include "../apm1_lib.txt"
.param VL=10

.param r0   = 4
.param r_R  = 3
.param r_O  = 1
.param r_E  = 0.5

.param v_r  = -0.1

.param tstop   = 50
.param maxstep = 0.01

.options plotwinsize=0
.options method=gear maxord=2 trtol=5 reltol=1e-6 abstol=1e-9 vntol=1e-9

B_TIME t 0 V = time
R_TIME t 0 1G

V_VEL vvel 0 DC {v_r}
XINT_R r vvel 0 INTpinv IC={r0} K=1 leak=0

XGAIN_RKM r_km r 0 GAIN K=10

XCMP_R flag_R r 0 0 CMPad th={r_R}
XCMP_O flag_O r 0 0 CMPad th={r_O}
XCMP_E flag_E r 0 0 CMPad th={r_E}

XEDR_R pulse_R flag_R 0 EDGE_F Td=0.02
XEDR_O pulse_O flag_O 0 EDGE_F Td=0.02
XEDR_E pulse_E flag_E 0 EDGE_F Td=0.02

XSH_O tO t pulse_O 0 S_H Ron=0.01 Ch=10m
XSH_E tE t pulse_E 0 S_H Ron=0.01 Ch=10m

XDT  dT   tE   tO   0 SUM Ku=1 Kd=-1

XTAU tauE t    tE   0 SUM Ku=1 Kd=-1

XERR e_rel dT  tauE 0 SUM Ku=1 Kd=-1

XCMP_REL flag_rel e_rel 0 0 CMPad th=0
XEDG_REL pulse_rel flag_rel 0 EDGE_F Td=0.02

.tran 0 {tstop} 0 {maxstep}

*=== RESULTS_BEGIN ===

.meas tran t_Rhine WHEN V(pulse_R)=0.5 RISE=1
.meas tran t_Oder  WHEN V(pulse_O)=0.5 RISE=1
.meas tran t_Elbe  WHEN V(pulse_E)=0.5 RISE=1
.meas tran t_rel   WHEN V(pulse_rel)=0.5 RISE=1

.meas tran dT_OE  PARAM='( t_Elbe - t_Oder )'
.meas tran dT_ER  PARAM='( t_rel  - t_Elbe )'

*=== RESULTS_END ===

.end
