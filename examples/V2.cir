* APM-1: V2
* Original description: ../docs/examples/V2_original.txt
* Current instructions and interpretation: ../docs/advanced_examples_pl.md
* Author of original examples: Dariusz Domal

.include "../apm1_lib.txt"
.param VL   = 10               ; [V] napięcie maszynowe pełnej skali
.param vFS  = 2000             ; [m/s] prędkość pełnoskalowa
.param fTB  = 30e6             ; [Hz] częstotliwość nadajnika BBA
.param c0   = 3e8              ; [m/s] prędkość światła

.param kv   = {vFS/VL}         ; [m/s/V] skala prędkości (200)
.param fDFS = 1000             ; [Hz] pełnoskalowa częstotliwość Dopplera
.param kf   = {fDFS/VL}        ; [Hz/V] skala częstotliwości (100)

.param Kfd = { 4*fTB*kv/(c0*kf) }

.param aM = 1

Va   acc 0 {aM}

XINT_V  vM  acc 0 INT PARAMS: IC=0 SIGN=1 leak=0

XFD   fDM  vM  0 GAIN PARAMS: K={Kfd}

XFHZ  fHz  fDM 0 GAIN PARAMS: K={kf}

XPHI  phi  fHz 0 INTp PARAMS: IC=0 SIGN=1 K={2*pi} leak=0

Bdop dop 0 V = { sin( V(phi,0) ) }

.options method=gear maxord=2 trtol=5 reltol=1e-6 abstol=1e-9 vntol=1e-9
.options maxstep = 10u

.tran 0 10 0 10u

*=== RESULTS_BEGIN ===
.meas tran v_final  FIND V(vM)          AT=10

.meas tran fD_final FIND { kf*V(fDM) }  AT=10
*=== RESULTS_END ===

.wave A4_Doppler_APM1.wav 16 44.1k V(dop)

.end
