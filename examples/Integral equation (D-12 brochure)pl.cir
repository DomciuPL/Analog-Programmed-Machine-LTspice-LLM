* D-12 compatibility entry point; one canonical executable model.
* See ../docs/advanced_examples_pl.md for the endpoint singularity.
.include "integral_equation_d12.cir"
